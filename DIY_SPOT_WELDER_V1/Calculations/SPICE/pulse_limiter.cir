* DIY_SPOT_WELDER_V1 - hardware pulse-length limiter + gate-drive UVLO (behavioural comparators)
* MCU GATE_CMD (5 V) -> R_SER 2.2k -> node GIN (TC4422 IN) with 22k pull-down
* RC timer: GATE_CMD -> R 68k -> CT 1u ; discharge diode 1N4148 + 4.7k back to GATE_CMD
* U1A (LM393): IN- = CT, IN+ = VTH = 5V*22k/32k ; open-collector output on GIN
* U1B (LM393): IN+ = VDRV*10k/(22k+10k) , IN- = 2.5 V (from 5V via 10k/10k) ; OC output on GIN
.param VDRV_LOW=0
V5    v5 0 DC 5
* MCU command: 40 ms pulse, 10 ms gap, then stuck HIGH (simulated firmware lock-up) at 60 ms
Vcmd  cmd 0 PWL(0 0 5m 0 5.001m 4.9 45m 4.9 45.001m 0 55m 0 55.001m 4.9 400m 4.9)
Rser  cmd gin 2.2k
Rpd   gin 0 22k
Rt    cmd ct 68k
Rdis  ct dd 4.7k
Ddis  dd cmd D1N4148
Ct    ct 0 1u IC=0
Rth1  v5 vth 10k
Rth2  vth 0 22k
* gate driver supply drops at 300 ms (to test UVLO) - irrelevant while limiter is tripped
Vdrv  vdrv 0 PWL(0 11.5 300m 11.5 300.1m 7.0 400m 7.0)
Ru1   vdrv vsen 22k
Ru2   vsen 0 10k
Rr1   v5 vref 10k
Rr2   vref 0 10k
* LM393 open collector: sink when IN+ < IN-  (modelled as voltage-controlled switch to GND, Ron 60 ohm)
SA    gin 0 ct vth SWOC
SB    gin 0 vref vsen SWOC
.model SWOC SW(Ron=60 Roff=100Meg Vt=0 Vh=0.002)
.model D1N4148 D(Is=2.52n N=1.752 Rs=0.568 Cjo=4p)
.tran 50u 400m 0 50u uic
.control
  run
  * time at which GIN falls below the TC4422 low threshold (0.8 V) after the stuck command at 55 ms
  meas tran t_trip WHEN v(gin)=0.8 FALL=2
  meas tran t_trip1 WHEN v(gin)=0.8 FALL=1
  meas tran v_ct_end1 MAX v(ct) from=5m to=46m
  meas tran v_gin_high AVG v(gin) from=10m to=40m
  meas tran v_gin_after MAX v(gin) from=150m to=400m
  wrdata pulse_limiter.dat v(cmd) v(ct) v(gin)
  quit
.endc
.end
